* RC low-pass and high-pass filters
VIN IN 0 AC 1
RLP IN LOW 1k
CLP LOW 0 {C}
CHP IN HIGH {C}
RHP HIGH 0 1k
.ac dec 60 1 10000000.0
.temp 27
.options reltol=1e-5 plotwinsize=0
.step param C list 10n 100n 1u
.save V(HIGH) V(IN) V(LOW) I(VIN) I(RLP) I(CLP) I(CHP) I(RHP)
.end
