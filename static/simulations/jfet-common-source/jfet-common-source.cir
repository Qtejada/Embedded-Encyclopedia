* JFET common-source amplifier
VDD VDD 0 12
VIN GATE 0 0 AC 1
J1 OUT GATE SOURCE J_NCHANNEL
RD VDD OUT {Rd}
RS SOURCE 0 1k
CS SOURCE 0 10u
.ac dec 60 10 10000000.0
.temp 27
.options reltol=1e-5 plotwinsize=0
.step param Rd list 1k 2.2k 3.3k
.model J_NCHANNEL NJF(Vto=-2 Beta=1.5m Lambda=0.005 Is=1f Cgs=5p Cgd=3p)
.save V(GATE) V(OUT) V(SOURCE) V(VDD) I(VDD) I(VIN) Id(J1) I(RD) I(RS) I(CS)
.end
