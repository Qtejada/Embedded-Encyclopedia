* Discrete amplifier with negative feedback
VP VP 0 12
VN VN 0 -12
VIN IN 0 0 AC 1
Q1 C1 IN TAIL 0 Q_NPN
Q2 VP FB TAIL 0 Q_NPN
IT TAIL VN 2m
RC VP C1 620
Q3 VAS C1 VP 0 Q_PNP
IVAS VAS VN 1m
Q4 VP VAS OUT 0 Q_NPN
IO OUT VN 2m
RF OUT FB 9k
RG FB 0 1k
RL OUT 0 10k
CC C1 VAS {Cc}
.ac dec 60 10 10000000.0
.temp 27
.options reltol=1e-5 plotwinsize=0
.step param Cc list 100p 470p 2.2n
.model Q_NPN NPN(Is=1e-14 Bf=150 Vaf=100 Cje=10p Cjc=4p Tf=300p)
.model Q_PNP PNP(Is=1e-14 Bf=150 Vaf=100 Cje=10p Cjc=4p Tf=300p)
.save V(C1) V(FB) V(IN) V(OUT) V(TAIL) V(VAS) V(VN) V(VP) I(VP) I(VN) I(VIN) Ic(Q1) Ib(Q1) Ic(Q2) Ib(Q2) I(IT) I(RC) Ic(Q3) Ib(Q3) I(IVAS) Ic(Q4) Ib(Q4) I(IO) I(RF) I(RG) I(RL) I(CC)
.end
