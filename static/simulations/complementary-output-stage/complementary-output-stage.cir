* Complementary output stage and class AB bias
VP VP 0 12
VN VN 0 -12
VIN IN 0 SINE(0 2 1k)
VBH BH IN {Bias}
VBL IN BL {Bias}
Q1 VP BH EN 0 Q_NPN
Q2 VN BL EP 0 Q_PNP
REN EN OUT 2.2
REP EP OUT 2.2
RL OUT 0 100
.tran 0 0.004 0.002 2e-07
.temp 27
.options reltol=1e-5 plotwinsize=0
.step param Bias list 0 0.55 0.65
.model Q_NPN NPN(Is=1e-14 Bf=150 Vaf=100 Cje=10p Cjc=4p Tf=300p)
.model Q_PNP PNP(Is=1e-14 Bf=150 Vaf=100 Cje=10p Cjc=4p Tf=300p)
.save V(BH) V(BL) V(EN) V(EP) V(IN) V(OUT) V(VN) V(VP) I(VP) I(VN) I(VIN) I(VBH) I(VBL) Ic(Q1) Ib(Q1) Ic(Q2) Ib(Q2) I(REN) I(REP) I(RL)
.end
