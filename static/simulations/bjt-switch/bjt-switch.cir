* BJT switch and base drive
VCC VCC 0 5
VIN IN 0 PULSE(0 3.3 1m 2u 2u 1m 2m)
RB IN BASE {Rb}
RL VCC OUT 100
Q1 OUT BASE 0 0 Q_NPN
.tran 0 0.006 0 2e-07
.temp 27
.options reltol=1e-5 plotwinsize=0
.step param Rb list 1k 10k 100k
.model Q_NPN NPN(Is=1e-14 Bf=150 Vaf=100 Cje=10p Cjc=4p Tf=300p)
.save V(BASE) V(IN) V(OUT) V(VCC) I(VCC) I(VIN) I(RB) I(RL) Ic(Q1) Ib(Q1)
.end
