* Emitter degeneration and current gain
VCC VCC 0 12
VIN IN 0 0 AC 1
RTA VCC BASEA 100k
RBA BASEA 0 22k
CIA IN BASEA 10u
QA COLA BASEA EMA 0 Q_VARIABLE
RCA VCC COLA 3.3k
REA EMA LOWA 1
RSA LOWA 0 999
CEA LOWA 0 100u
COA COLA OUTA 10u
RLA OUTA 0 100k
RTB VCC BASEB 100k
RBB BASEB 0 22k
CIB IN BASEB 10u
QB COLB BASEB EMB 0 Q_VARIABLE
RCB VCC COLB 3.3k
REB EMB LOWB 100
RSB LOWB 0 900
CEB LOWB 0 100u
COB COLB OUTB 10u
RLB OUTB 0 100k
.ac dec 60 10 10000000.0
.temp 27
.options reltol=1e-5 plotwinsize=0
.step param Beta list 50 150 300
.model Q_VARIABLE NPN(Is=1e-14 Bf={Beta} Vaf=100)
.save V(BASEA) V(BASEB) V(COLA) V(COLB) V(EMA) V(EMB) V(IN) V(LOWA) V(LOWB) V(OUTA) V(OUTB) V(VCC) I(VCC) I(VIN) I(RTA) I(RBA) I(CIA) Ic(QA) Ib(QA) I(RCA) I(REA) I(RSA) I(CEA) I(COA) I(RLA) I(RTB) I(RBB) I(CIB) Ic(QB) Ib(QB) I(RCB) I(REB) I(RSB) I(CEB) I(COB) I(RLB)
.end
