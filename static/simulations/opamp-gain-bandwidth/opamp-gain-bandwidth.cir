* Closed-loop gain and bandwidth
VP VP 0 12
VN VN 0 -12
VIN IN 0 0 AC 1
RG FB 0 1k
RF OUT FB {Rf}
XU1 IN FB VP VN OUT level2 Avol=1Meg GBW=1Meg Slew=10Meg Ilimit=100m Rail=0.5 Vos=0 En=0 Enk=0 In=0 Ink=0 Rin=1G
.lib UniversalOpAmp2.lib
.ac dec 60 10 10000000.0
.temp 27
.options reltol=1e-5 plotwinsize=0
.step param Rf list 1k 9k 99k
.save V(FB) V(IN) V(OUT) V(VN) V(VP) I(VP) I(VN) I(VIN) I(RG) I(RF)
.end
