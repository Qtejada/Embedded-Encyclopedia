* Practical integrator
VP VP 0 12
VN VN 0 -12
VIN IN 0 0 AC 1
RI IN SUM 10k
CF OUT SUM {Cf}
RF OUT SUM 1Meg
XU1 0 SUM VP VN OUT level2 Avol=1Meg GBW=10Meg Slew=10Meg Ilimit=100m Rail=0.5 Vos=0 En=0 Enk=0 In=0 Ink=0 Rin=1G
.lib UniversalOpAmp2.lib
.ac dec 60 1 1000000.0
.temp 27
.options reltol=1e-5 plotwinsize=0
.step param Cf list 10n 100n 1u
.save V(IN) V(OUT) V(SUM) V(VN) V(VP) I(VP) I(VN) I(VIN) I(RI) I(CF) I(RF)
.end
